# Ansys Electronics Desktop project, version 2021.2
materials:
  vacuum: permittivity=1
  copper: permeability=0.999991 conductivity=58000000

design Maxwell3DDesign1 (Maxwell 3D, Magnetostatic, model units mm)
geometry:
  Polygon1 = regular_polygon(axis=X, centre=(0mm, 5mm, 0mm), first_corner=(0mm, 4mm, 0mm), sides=8)
  Polygon1.spiral(IsSpiral XCenter=0mm YCenter=0mm ZCenter=0mm XStartDir=0mm YStartDir=0mm ZStartDir=1mm NumThread=30 RightHand=true RadiusIncrement=2.5mm)
  Polyline1 [copper] = polyline(x=0mm, yz in mm: (5, -1) (5, 5) (80, 5) (80, -1), section rectangle width=2mm height=2mm)
  Polyline1.unite(Polygon1)
  Polyline1_Section1 = Polyline1.section(plane=ZX)
  Polyline1_Section1.separate_bodies()
  Polygon3 [copper] = regular_polygon(axis=X, centre=(0mm, 5mm, 10mm), first_corner=(0mm, 4mm, 10mm), sides=8)
  Polygon3.spiral(IsSpiral XCenter=0mm YCenter=0mm ZCenter=0mm XStartDir=0mm YStartDir=0mm ZStartDir=10mm NumThread=30 RightHand=true RadiusIncrement=2.5mm)
  Polyline3 = polyline(x=0mm, yz in mm: (5, 10) (5, 15) (80, 15) (80, 8), section rectangle width=2mm height=2mm)
  Polygon3.unite(Polyline3)
  Polygon3_Section1 = Polygon3.section(plane=ZX)
  Polygon3_Section1.separate_bodies()
  Sphere1 [vacuum] = sphere(centre=(0mm, 0mm, 0mm), radius=100mm)
boundaries and excitations:
  ZeroTangentialHField1: Zero Tangential H Field Faces=Sphere1.face(1 of 1)
  Current1: Current Objects=Polyline1_Section1 Current=1A IsSolid=false Point_out_of_terminal=false
  Current2: Current Objects=Polygon3_Section1 Current=1A IsSolid=false Point_out_of_terminal=false
parameters:
  Matrix1: Matrix Current1, Current2: NumberOfTurns=1
mesh:
  initial mesh: GlobalCurvilinear{Apply}
setups:
  Setup1: Magnetostatic MaximumPasses=10 MinimumPasses=2 MinimumConvergedPasses=1 PercentRefinement=30 PercentError=1 NonLinearResidual=0.001
field plots:
  Mag_B1, Mag_B2: B over a plane on Setup1 : LastAdaptive
  H_Vector1: H over a plane on Setup1 : LastAdaptive
reports:
  L Table 1: Matrix1.L(Current1,Current1), Matrix1.L(Current2,Current1), Matrix1.L(Current1,Current2), Matrix1.L(Current2,Current2) vs X on Setup1 : LastAdaptive
  Coupling Coeff Table 1: Matrix1.CplCoef(Current1,Current1), Matrix1.CplCoef(Current1,Current2), Matrix1.CplCoef(Current2,Current2), Matrix1.L(Current1,Current1), Matrix1.L(Current1,Current2), Matrix1.L(Current2,Current2) vs X on Setup1 : LastAdaptive
  L Table 2: Matrix1.L(Current1,Current1), Matrix1.L(Current2,Current1), Matrix1.L(Current1,Current2), Matrix1.L(Current2,Current2) vs X on Setup1 : LastAdaptive
